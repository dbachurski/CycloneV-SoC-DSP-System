addrmap csr {
    default regwidth = 32;

    reg {
        field {
            sw = rw;
            hw = na;
        } res[31:8] = 0;
        field {
            sw = rw;
            hw = r;
        } val[7:0] = 0;
    } IO_CR @ 0x000;

    reg {
        field {
            sw = rw;
            hw = na;
        } res [31:18] = 0;
        field {
            sw = rw;
            hw = r;
        } dft_number_of_points[17:3] = 0;
        field {
            sw = rw;
            hw = r;
        } dft_reset[2:2] = 0;
        field {
            sw = rw;
            hw = r;
        } dft_enable[1:1] = 0;
        field {
            sw = rw;
            hw = r;
        } fir_enable[0:0] = 0;
    } DSP_CR @ 0x004;

    reg {
        field {
            sw = rw;
            hw = na;
        } res [31:3] = 0;
        field {
            sw = r;
            hw = rw;
        } dft_status[2:0] = 0;
    } DSP_SR @ 0x008;

    reg {
        field {
            sw = rw;
            hw = r;
        } val[31:0] = 0;
    } fir_coeff_0 @ 0x100;

    reg {
        field {
            sw = rw;
            hw = r;
        } val[31:0] = 0;
    } fir_coeff_1;

    reg {
        field {
            sw = rw;
            hw = r;
        } val[31:0] = 0;
    } fir_coeff_2;

    reg {
        field {
            sw = rw;
            hw = r;
        } val[31:0] = 0;
    } fir_coeff_3;

    reg {
        field {
            sw = rw;
            hw = r;
        } val[31:0] = 0;
    } fir_coeff_4;

    reg {
        field {
            sw = rw;
            hw = r;
        } val[31:0] = 0;
    } fir_coeff_5;

    reg {
        field {
            sw = rw;
            hw = r;
        } val[31:0] = 0;
    } fir_coeff_6;

    reg {
        field {
            sw = rw;
            hw = r;
        } val[31:0] = 0;
    } fir_coeff_7;

    reg {
        field {
            sw = rw;
            hw = r;
        } val[31:0] = 0;
    } fir_coeff_8;

    reg {
        field {
            sw = rw;
            hw = r;
        } val[31:0] = 0;
    } fir_coeff_9;

    reg {
        field {
            sw = rw;
            hw = r;
        } val[31:0] = 0;
    } fir_coeff_10;

    reg {
        field {
            sw = rw;
            hw = r;
        } val[31:0] = 0;
    } fir_coeff_11;

    reg {
        field {
            sw = rw;
            hw = r;
        } val[31:0] = 0;
    } fir_coeff_12;

    reg {
        field {
            sw = rw;
            hw = r;
        } val[31:0] = 0;
    } fir_coeff_13;

    reg {
        field {
            sw = rw;
            hw = r;
        } val[31:0] = 0;
    } fir_coeff_14;

    reg {
        field {
            sw = rw;
            hw = r;
        } val[31:0] = 0;
    } fir_coeff_15;
};