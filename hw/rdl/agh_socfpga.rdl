addrmap csr {
    default regwidth = 32;

    reg {
        field {
            sw = rw;
            hw = r;
        } val[7:0] = 0;

    } IO_CR @ 0x000;

    reg {
        field {
            sw = rw;
            hw = na;
            hwset;
        } val[0:0] = 0;

    } TEST_REG @ 0x004;

    reg {
        field {
            sw = rw;
            hw = na;
        } val[31:0] = 0;

    } SCRATCHPAD @ 0x3fc;
};